* --- control ---

* Test Circuit - Stimulus for EIS
V_source 100 0 AC 1V
X_cell 100 0 RandlesCell

* AC Analysis settings
.ac dec 10 0.001 10000000.0

.control
  run
  set units = si

  * Define the Frequency vector
  let freq = frequency

  * Calculate Complex Impedance
  * Note: I(V_source) is negative convention in SPICE, so we use -I to get positive Z
  let Z = V(100) / -I(V_source)

  * Extract Components for EIS Analysis
  let Z_mag = abs(Z)
  let Z_phase = ph(Z)
  let Z_real = real(Z)
  let Z_imag = imag(Z)

  * Output to console (for parsing)
  print freq Z_mag Z_phase

  * Save data to file
  wrdata eis_data.txt Z_real Z_imag Z_mag Z_phase

.endc

.end
